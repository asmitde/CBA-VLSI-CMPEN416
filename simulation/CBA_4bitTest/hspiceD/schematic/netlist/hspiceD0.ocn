simulator( 'hspiceD )
design(	 "/home/grads/sms821/EE416/simulation/CBA_4bitTest/hspiceD/schematic/netlist/netlist")
resultsDir( "/home/grads/sms821/EE416/simulation/CBA_4bitTest/hspiceD/schematic" )
modelFile(
    '("/home/software/cadence/local/ncsu/models/hspice/public/tsmc20N.m" "")
    '("/home/software/cadence/local/ncsu/models/hspice/public/tsmc20P.m" "")
)
analysis('tran ?start "0"  ?stop "3u"  ?step "0.01u"  )
desVar(	  "beta" ""	)
option(	'TEMPDC  "25.0"
)
temp( 25.0 )
run()
