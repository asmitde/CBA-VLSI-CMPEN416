simulator( 'hspiceD )
design(	 "/home/grads/sms821/EE416/simulation/NAND_tb/hspiceD/schematic/netlist/netlist")
resultsDir( "/home/grads/sms821/EE416/simulation/NAND_tb/hspiceD/schematic" )
modelFile(
    '("/home/software/cadence/local/ncsu/models/hspice/public/tsmc20N.m" "")
    '("/home/software/cadence/local/ncsu/models/hspice/public/tsmc20P.m" "")
)
analysis('tran ?start "0"  ?stop "3u"  ?step "0.01u"  )
option(	'TEMPDC  "25.0"
)
temp( 25.0 )
run()
modelFile(
    '("/home/software/cadence/local/ncsu/models/hspice/public/tsmc20N.m" "")
    '("/home/software/cadence/local/ncsu/models/hspice/public/tsmc20P.m" "")
)
run()
selectResult( 'tran )
plot(getData("/net5") )
delay = delay(?wf1 VT("/net5") ?value1 0.9 ?edge1 "falling" ?nth1 1 ?td1 0.0 ?wf2 VT("/net3") ?value2 0.9 ?edge2 "rising" ?nth2 1 ?td2 nil ?stop nil ?multiple nil)
plot( delay ?expr '( "delay" ) )
