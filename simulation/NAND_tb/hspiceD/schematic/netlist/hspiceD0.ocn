simulator( 'hspiceD )
design(	 "/home/grads/sms821/EE416/simulation/NAND_tb/hspiceD/schematic/netlist/netlist")
resultsDir( "/home/grads/sms821/EE416/simulation/NAND_tb/hspiceD/schematic" )
analysis('tran ?start "0"  ?stop "3u"  ?step "0.01u"  )
option(	'TEMPDC  "25.0"
)
temp( 25.0 )
run()
run()
run()
run()
