simulator( 'hspiceD )
design(	 "/home/grads/sms821/EE416/simulation/CBA_4bit/hspiceD/schematic/netlist/netlist")
resultsDir( "/home/grads/sms821/EE416/simulation/CBA_4bit/hspiceD/schematic" )
modelFile(
    '("/home/software/cadence/local/ncsu/models/hspice/public/tsmc20N.m" "")
    '("/home/software/cadence/local/ncsu/models/hspice/public/tsmc20P.m" "")
)
analysis('tran ?start "0"  ?stop "3u"  ?step "0.01u"  )
desVar(	  "beta" 2	)
option(	'TEMPDC  "25.0"
)
temp( 25.0 )
run()
fallTime = fallTime(VT("/Co_3") 1.8 nil 0 nil 10 90 nil "time")
plot( fallTime ?expr '( "fallTime" ) )
riseTime = riseTime(VT("/Co_3") 0 nil 1.8 nil 10 90 nil "time")
plot( riseTime ?expr '( "riseTime" ) )
modelFile(
    '("/home/software/cadence/local/ncsu/models/hspice/public/tsmc20N.m" "")
    '("/home/software/cadence/local/ncsu/models/hspice/public/tsmc20P.m" "")
)
run()
fallTime = fallTime(VT("/Co_3") 1.8 nil 0 nil 10 90 nil "time")
plot( fallTime ?expr '( "fallTime" ) )
riseTime = riseTime(VT("/Co_3") 0 nil 1.8 nil 10 90 nil "time")
plot( riseTime ?expr '( "riseTime" ) )
modelFile(
    '("/home/software/cadence/local/ncsu/models/hspice/public/tsmc20N.m" "")
    '("/home/software/cadence/local/ncsu/models/hspice/public/tsmc20P.m" "")
)
run()
fallTime = fallTime(VT("/Co_3") 1.8 nil 0 nil 10 90 nil "time")
plot( fallTime ?expr '( "fallTime" ) )
riseTime = riseTime(VT("/Co_3") 0 nil 1.8 nil 10 90 nil "time")
plot( riseTime ?expr '( "riseTime" ) )
modelFile(
    '("/home/software/cadence/local/ncsu/models/hspice/public/tsmc20N.m" "")
    '("/home/software/cadence/local/ncsu/models/hspice/public/tsmc20P.m" "")
)
run()
fallTime = fallTime(VT("/Co_3") 1.8 nil 0 nil 10 90 nil "time")
plot( fallTime ?expr '( "fallTime" ) )
riseTime = riseTime(VT("/Co_3") 0 nil 1.8 nil 10 90 nil "time")
plot( riseTime ?expr '( "riseTime" ) )
modelFile(
    '("/home/software/cadence/local/ncsu/models/hspice/public/tsmc20N.m" "")
    '("/home/software/cadence/local/ncsu/models/hspice/public/tsmc20P.m" "")
)
run()
fallTime = fallTime(VT("/Co_3") 1.8 nil 0 nil 10 90 nil "time")
plot( fallTime ?expr '( "fallTime" ) )
riseTime = riseTime(VT("/Co_3") 0 nil 1.8 nil 10 90 nil "time")
plot( riseTime ?expr '( "riseTime" ) )
