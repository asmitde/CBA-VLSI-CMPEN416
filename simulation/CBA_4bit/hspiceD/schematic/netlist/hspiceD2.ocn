simulator( 'hspiceD )
design(	 "/home/grads/sms821/EE416/simulation/CBA_4bit/hspiceD/schematic/netlist/netlist")
resultsDir( "/home/grads/sms821/EE416/simulation/CBA_4bit/hspiceD/schematic" )
analysis('tran ?stop "3u"  )
desVar(	  "beta" 2	)
option(	'TEMPDC  "25.0"
)
temp( 25.0 )
run()
run()
