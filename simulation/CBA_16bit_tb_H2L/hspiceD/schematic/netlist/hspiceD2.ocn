simulator( 'hspiceD )
design(	 "/home/grads/sms821/EE416/simulation/CBA_16bit_tb_H2L/hspiceD/schematic/netlist/netlist")
resultsDir( "/home/grads/sms821/EE416/simulation/CBA_16bit_tb_H2L/hspiceD/schematic" )
modelFile(
    '("/home/software/cadence/local/ncsu/models/hspice/public/tsmc20N.m" "")
    '("/home/software/cadence/local/ncsu/models/hspice/public/tsmc20P.m" "")
)
analysis('tran ?start "0"  ?stop "3u"  ?step "0.01u"  )
option(	'TEMPDC  "25.0"
)
temp( 25.0 )
run()
modelFile(
    '("/home/software/cadence/local/ncsu/models/hspice/public/tsmc20N.m" "")
    '("/home/software/cadence/local/ncsu/models/hspice/public/tsmc20P.m" "")
)
save( 'i "/V0/PLUS" )
run()
riseTime_S15 = riseTime(VT("/S15") 0 nil 1.8 nil 10 90 nil "time")
plot( riseTime_S15 ?expr '( "riseTime_S15" ) )
fallTime_S15 = fallTime(VT("/S15") 1.8 nil 0 nil 10 90 nil "time")
plot( fallTime_S15 ?expr '( "fallTime_S15" ) )
riseDelay = delay(?wf1 VT("/A0") ?value1 0.9 ?edge1 "falling" ?nth1 1 ?td1 0.0 ?wf2 VT("/S15") ?value2 0.9 ?edge2 "rising" ?nth2 1 ?td2 nil ?stop nil ?multiple nil)
plot( riseDelay ?expr '( "riseDelay" ) )
fallDelay = delay(?wf1 VT("/A0") ?value1 0.9 ?edge1 "falling" ?nth1 1 ?td1 0.0 ?wf2 VT("/S15") ?value2 0.9 ?edge2 "falling" ?nth2 1 ?td2 nil ?stop nil ?multiple nil)
plot( fallDelay ?expr '( "fallDelay" ) )
power = average((VT("/net7") * IT("/V0/PLUS")))
plot( power ?expr '( "power" ) )
modelFile(
    '("/home/software/cadence/local/ncsu/models/hspice/public/tsmc20N.m" "")
    '("/home/software/cadence/local/ncsu/models/hspice/public/tsmc20P.m" "")
)
run()
riseTime_S15 = riseTime(VT("/S15") 0 nil 1.8 nil 10 90 nil "time")
plot( riseTime_S15 ?expr '( "riseTime_S15" ) )
fallTime_S15 = fallTime(VT("/S15") 1.8 nil 0 nil 10 90 nil "time")
plot( fallTime_S15 ?expr '( "fallTime_S15" ) )
riseDelay = delay(?wf1 VT("/A0") ?value1 0.9 ?edge1 "falling" ?nth1 1 ?td1 0.0 ?wf2 VT("/S15") ?value2 0.9 ?edge2 "rising" ?nth2 1 ?td2 nil ?stop nil ?multiple nil)
plot( riseDelay ?expr '( "riseDelay" ) )
fallDelay = delay(?wf1 VT("/A0") ?value1 0.9 ?edge1 "falling" ?nth1 1 ?td1 0.0 ?wf2 VT("/S15") ?value2 0.9 ?edge2 "falling" ?nth2 1 ?td2 nil ?stop nil ?multiple nil)
plot( fallDelay ?expr '( "fallDelay" ) )
power = average(((- VT("/net7")) * IT("/V0/PLUS")))
plot( power ?expr '( "power" ) )
modelFile(
    '("/home/software/cadence/local/ncsu/models/hspice/public/tsmc20N.m" "")
    '("/home/software/cadence/local/ncsu/models/hspice/public/tsmc20P.m" "")
)
run()
riseTime_S15 = riseTime(VT("/S15") 0 nil 1.8 nil 10 90 nil "time")
plot( riseTime_S15 ?expr '( "riseTime_S15" ) )
fallTime_S15 = fallTime(VT("/S15") 1.8 nil 0 nil 10 90 nil "time")
plot( fallTime_S15 ?expr '( "fallTime_S15" ) )
riseDelay = delay(?wf1 VT("/A0") ?value1 0.9 ?edge1 "falling" ?nth1 1 ?td1 0.0 ?wf2 VT("/S15") ?value2 0.9 ?edge2 "rising" ?nth2 1 ?td2 nil ?stop nil ?multiple nil)
plot( riseDelay ?expr '( "riseDelay" ) )
fallDelay = delay(?wf1 VT("/A0") ?value1 0.9 ?edge1 "falling" ?nth1 1 ?td1 0.0 ?wf2 VT("/S15") ?value2 0.9 ?edge2 "falling" ?nth2 1 ?td2 nil ?stop nil ?multiple nil)
plot( fallDelay ?expr '( "fallDelay" ) )
power = average(((- VT("/net7")) * IT("/V0/PLUS")))
plot( power ?expr '( "power" ) )
