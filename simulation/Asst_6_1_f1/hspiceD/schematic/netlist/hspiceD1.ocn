simulator( 'hspiceD )
design(	 "/home/grads/sms821/EE416/simulation/Asst_6_1_f1/hspiceD/schematic/netlist/netlist")
resultsDir( "/home/grads/sms821/EE416/simulation/Asst_6_1_f1/hspiceD/schematic" )
modelFile(
    '("/home/software/cadence/local/ncsu/models/hspice/public/tsmc20P.m" "")
    '("/home/software/cadence/local/ncsu/models/hspice/public/tsmc20N.m" "")
)
analysis('tran ?start "0"  ?stop "3u"  ?step "0.01u"  )
desVar(	  "Wp" 300n	)
option(	'TEMPDC  "25.0"
)
temp( 25.0 )
run()
