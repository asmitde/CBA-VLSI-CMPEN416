simulator( 'hspiceD )
design(	 "/home/grads/sms821/EE416/simulation/CBA_16bit_tb/hspiceD/schematic/netlist/netlist")
resultsDir( "/home/grads/sms821/EE416/simulation/CBA_16bit_tb/hspiceD/schematic" )
modelFile(
    '("/home/software/cadence/local/ncsu/models/hspice/public/tsmc20N.m" "")
    '("/home/software/cadence/local/ncsu/models/hspice/public/tsmc20P.m" "")
)
analysis('tran ?start "0"  ?stop "3u"  ?step "0.01u"  )
option(	'TEMPDC  "25.0"
)
temp( 25.0 )
run()
modelFile(
    '("/home/software/cadence/local/ncsu/models/hspice/public/tsmc20N.m" "")
    '("/home/software/cadence/local/ncsu/models/hspice/public/tsmc20P.m" "")
)
run()
delay_Cout = delay(?wf1 VT("/Cout") ?value1 0.9 ?edge1 "falling" ?nth1 1 ?td1 0.0 ?wf2 VT("/Cout") ?value2 0.9 ?edge2 "rising" ?nth2 1 ?td2 nil ?stop nil ?multiple nil)
plot( delay_Cout ?expr '( "delay_Cout" ) )
delay_S13 = delay(?wf1 VT("/S13") ?value1 0.9 ?edge1 "falling" ?nth1 1 ?td1 0.0 ?wf2 VT("/Cout") ?value2 0.9 ?edge2 "rising" ?nth2 1 ?td2 nil ?stop nil ?multiple nil)
plot( delay_S13 ?expr '( "delay_S13" ) )
modelFile(
    '("/home/software/cadence/local/ncsu/models/hspice/public/tsmc20N.m" "")
    '("/home/software/cadence/local/ncsu/models/hspice/public/tsmc20P.m" "")
)
run()
delay_Cout = delay(?wf1 VT("/Cout") ?value1 0.9 ?edge1 "rising" ?nth1 1 ?td1 0.0 ?wf2 VT("/A0") ?value2 0.9 ?edge2 "rising" ?nth2 1 ?td2 nil ?stop nil ?multiple nil)
plot( delay_Cout ?expr '( "delay_Cout" ) )
modelFile(
    '("/home/software/cadence/local/ncsu/models/hspice/public/tsmc20N.m" "")
    '("/home/software/cadence/local/ncsu/models/hspice/public/tsmc20P.m" "")
)
run()
delay_Cout = delay(?wf1 VT("/Cout") ?value1 0.9 ?edge1 "rising" ?nth1 1 ?td1 0.0 ?wf2 VT("/A0") ?value2 0.9 ?edge2 "rising" ?nth2 1 ?td2 nil ?stop nil ?multiple nil)
plot( delay_Cout ?expr '( "delay_Cout" ) )
delayagain = delay(?wf1 VT("/A0") ?value1 0.9 ?edge1 "rising" ?nth1 1 ?td1 0.0 ?wf2 VT("/Cout") ?value2 0.9 ?edge2 "rising" ?nth2 1 ?td2 nil ?stop nil ?multiple nil)
plot( delayagain ?expr '( "delayagain" ) )
